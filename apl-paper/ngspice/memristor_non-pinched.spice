.subckt memristor_nonpinched TE BE xsv a1=0.17 a2=0.17 b1=0.05 b2=0.05
+Vp=0.65 Vn=0.56 Ap=4000 An=4000 xp=0.3 xn=0.5 alphap=1 alphan=5 xo=0.11 eta=1
+xsvo=2.075 u1=0 u2=0 k1=0.1356 k2=3.1034
* Multiplicitive functions to ensure zero state
* variable motion at memristor boundaries
.func wp(V) = {xp/(1-xp) - V/(1-xp) + 1}
.func wn(V) = {V/(1-xn)}

* Define function 'IF'
.func IF(a,b,c) {ternary_fcn( a , b , c )}

* Function G(V(t)) - Describes the device threshold
.func G(V) = {IF(V <= Vp, IF(V >= -Vn, 0, -An*(exp(-
+V)-exp(Vn))), Ap*(exp(V)-exp(Vp)))}

* Function F(V(t),x(t)) - Describes the SV motion
.func F(V1,V2) = {IF(eta*V1 >= 0, IF(V2 >= xp, exp(-
+alphap*(V2-xp))*wp(V2) ,1), IF(V2 <= (1-xn),
+exp(alphan*(V2+xn-1))*wn(V2) ,1))}

* IV Response - Hyperbolic sine due to MIM structure
.func IVRel(V1,V2) = {IF(V2 <= xsvo,IF(V1 >= u2, k1*a1*V2*sinh(b1*(V1-u2)),
+k2*a2*V2*sinh(b2*(V1-u2))),IF(V1 >= u1, a1*V2*sinh(b1*(V1-u1)),
+a2*V2*sinh(b2*(V1-u1))))}

* Circuit to determine state variable
* dx/dt = F(V(t),x(t))*G(V(t))
Cx xsv 0 {1}
.ic V(xsv) = xo
Gx 0 xsv value={eta*F(V(BE)-V(TE),V(xsv)-V(0))*G(V(BE)-V(TE)))}

* Current source for memristor IV response
Gm TE BE value = {IVRel((V(BE)-V(TE)),V(xsv)-V(0))}

.ends memristor_nonpinched
